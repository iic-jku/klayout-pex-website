* Distributed conductors with capacitor-only floating fill
.subckt coupled A B VSS
Rext_a A A1 100
Rext_b B B1 200
* netlist ground: exact floating elimination, then full inter-net loads to VSS
Cgrnd_1 A1 VSS 5p
Cgrnd_2 B1 VSS 4p
Cload A VSS 5p
.ends coupled
