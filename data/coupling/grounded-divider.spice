* Two retained terminals and one capacitor-only floating node
.subckt divider A B VSS
* netlist ground: exact floating elimination, then full inter-net loads to VSS
Cgrnd_1 A VSS 2p
Cgrnd_2 B VSS 2p
.ends divider
